/*
IMPORTANT NOTICE:
THIS SOFTWARE IS LICENSED TO YOU UNDER THE TERMS OF THE SYNOPSYS END-USER LICENSE
AGREEMENT FOR SAMPLE VERILOG-A MODELS. YOU CAN VIEW THE LICENSE AT:
      http://www.synopsys.com/cgi-bin/hspice/models/license.cgi
SYNOPSYS, INC. WILL ONLY PERMIT YOU TO USE THIS SOFTWARE ON THE CONDITION THAT YOU
ACCEPT ALL OF THE TERMS CONTAINED IN THIS LICENSE AGREEMENT.  YOU ACCEPT THESE TERMS
BY DOWNLOADING, INSTALLING OR USING THIS SOFTWARE. IF YOU ARE UNWILLING TO ACCEPT THE
TERMS OF THE LICENSE AGREEMENT, THEN  DO NOT DOWNLOAD, INSTALL OR USE THE SOFTWARE.
*/
// Version 1.0   September 2006
`include "constants.vams"
`include "disciplines.vams"

module amp2(out, in);
inout out, in;
electrical out, in;
parameter real Gain = 1 (* type="instance" xyceAlsoModel="yes" *) ;
parameter real , Rin = 1, Cin = 1, Rout = 1, Lout = 1 ;
analog begin
// gain of amplifier
V(out) <+ Gain*V(in);
// model input admittance
I(in) <+ V(in)/Rin;
I(in) <+ Cin*ddt(V(in));
// model output impedance
V(out) <+ Rout*I(out);
V(out) <+ Lout*ddt(I(out));
end
endmodule

/*
IMPORTANT NOTICE:
THIS SOFTWARE IS LICENSED TO YOU UNDER THE TERMS OF THE SYNOPSYS END-USER LICENSE
AGREEMENT FOR SAMPLE VERILOG-A MODELS. YOU CAN VIEW THE LICENSE AT:
      http://www.synopsys.com/cgi-bin/hspice/models/license.cgi
SYNOPSYS, INC. WILL ONLY PERMIT YOU TO USE THIS SOFTWARE ON THE CONDITION THAT YOU
ACCEPT ALL OF THE TERMS CONTAINED IN THIS LICENSE AGREEMENT.  YOU ACCEPT THESE TERMS
BY DOWNLOADING, INSTALLING OR USING THIS SOFTWARE. IF YOU ARE UNWILLING TO ACCEPT THE
TERMS OF THE LICENSE AGREEMENT, THEN  DO NOT DOWNLOAD, INSTALL OR USE THE SOFTWARE.
*/
// Version 1.0   September 2006
`include "disciplines.vams"

// Verilog-A module for flicker noise source
//   consistent with LRM v2.2, page 87.

module flickerNoise(p, n);
   inout p, n;
   electrical p, n;
   parameter real kf=1.0e-20 from [0:inf) (* type="instance" xyceAlsoModel="yes" *);
   parameter real ef=1.0 from [0:2.0] ;

   analog begin
      // noise power = kf*f^-ef
      I(p, n) <+ flicker_noise(kf, ef, "flicker");
   end
endmodule

/*
IMPORTANT NOTICE:
THIS SOFTWARE IS LICENSED TO YOU UNDER THE TERMS OF THE SYNOPSYS END-USER LICENSE
AGREEMENT FOR SAMPLE VERILOG-A MODELS. YOU CAN VIEW THE LICENSE AT:
      http://www.synopsys.com/cgi-bin/hspice/models/license.cgi
SYNOPSYS, INC. WILL ONLY PERMIT YOU TO USE THIS SOFTWARE ON THE CONDITION THAT YOU
ACCEPT ALL OF THE TERMS CONTAINED IN THIS LICENSE AGREEMENT.  YOU ACCEPT THESE TERMS
BY DOWNLOADING, INSTALLING OR USING THIS SOFTWARE. IF YOU ARE UNWILLING TO ACCEPT THE
TERMS OF THE LICENSE AGREEMENT, THEN  DO NOT DOWNLOAD, INSTALL OR USE THE SOFTWARE.
*/
// Version 1.0   September 2006
`include "disciplines.vams"
module diode(a, c);
electrical a, c;
inout a, c;
parameter real IS = 1.0e-14 ;
real idio;
(*desc = "small-signal conductance" *)
    real gdio;
analog begin
    idio
    = IS * (limexp(V(a, c) / $vt) - 1);
// gdio = ddx(idio, V(a));
I(a, c) < +idio;
end
endmodule
